* RC low pass filter - reference deck for the test-suite
* fc = 1 / (2*pi*R*C) = 1 / (2*pi*1k*159.155n) = 1000 Hz
V1 in 0 DC 0 AC 1 SIN(0 1 1k)
R1 in out 1k
C1 out 0 159.155n

.ac dec 200 10 100k
.tran 10u 5m
.end
